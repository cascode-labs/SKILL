procedure(proc_alt_sh_scroll_up()
	when(geGetSelSet()
		txpose_inst_label('t))
)

procedure( proc_alt_sh_scroll_down()
	when(geGetSelSet() then
		txpose_inst_label(nil))
)
